// `circuit.Package` `gplugins.parcirc.example.correct_pads`
// Generated by `vlsirtools.SpectreNetlister`
//

subckt straight_e0091ba5
  + 1
  + // No parameters

ends

subckt straight_af1bc243
  + 1
  + // No parameters

ends

subckt straight_ea93caa4
  + 1
  + // No parameters

ends

subckt bend_euler_cross_sectionmetal3
  + 1
  + // No parameters

ends

subckt straight_55343d8d
  + 1
  + // No parameters

ends

subckt pad
  + 1
  + // No parameters

ends

subckt pads_correct
  + // No ports
  + // No parameters

  1
  + // Ports:
  + ( tl,tr )
  +  pad
  + // No parameters

  2
  + // Ports:
  + ( tl,tr )
  +  straight_ea93caa4
  + // No parameters

  3
  + // Ports:
  + ( tl,tr )
  +  bend_euler_cross_sectionmetal3
  + // No parameters

  4
  + // Ports:
  + ( tl,tr )
  +  straight_af1bc243
  + // No parameters

  5
  + // Ports:
  + ( tl,tr )
  +  bend_euler_cross_sectionmetal3
  + // No parameters

  6
  + // Ports:
  + ( tl,tr )
  +  pad
  + // No parameters

  7
  + // Ports:
  + ( tl,tr )
  +  straight_e0091ba5
  + // No parameters

  8
  + // Ports:
  + ( bl,br )
  +  pad
  + // No parameters

  9
  + // Ports:
  + ( bl,br )
  +  straight_55343d8d
  + // No parameters

  10
  + // Ports:
  + ( bl,br )
  +  pad
  + // No parameters

ends
