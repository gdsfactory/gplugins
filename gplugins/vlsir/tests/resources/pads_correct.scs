// `circuit.Package` `gplugins.klayout.example`
// Generated by `vlsirtools.SpectreNetlister`
//

subckt taper_L10_W100_W10_LNon_43bc52bd
  + 1
  + // No parameters

ends

subckt pad_S100_100_LMTOP_BLNo_163fd346
  + 1 2
  + // No parameters

ends

subckt pads_correct_Ppad_CSmetal3
  + // No ports
  + // No parameters

  1
  + // Ports:
  + ( tl,tr tl )
  +  pad_S100_100_LMTOP_BLNo_163fd346
  + // No parameters

  2
  + // Ports:
  + ( tl,tr )
  +  taper_L10_W100_W10_LNon_43bc52bd
  + // No parameters

  3
  + // Ports:
  + ( tl,tr tr )
  +  pad_S100_100_LMTOP_BLNo_163fd346
  + // No parameters

  4
  + // Ports:
  + ( tl,tr )
  +  taper_L10_W100_W10_LNon_43bc52bd
  + // No parameters

  5
  + // Ports:
  + ( bl,br br )
  +  pad_S100_100_LMTOP_BLNo_163fd346
  + // No parameters

  6
  + // Ports:
  + ( bl,br bl )
  +  pad_S100_100_LMTOP_BLNo_163fd346
  + // No parameters

  7
  + // Ports:
  + ( bl,br )
  +  taper_L10_W100_W10_LNon_43bc52bd
  + // No parameters

  8
  + // Ports:
  + ( bl,br )
  +  taper_L10_W100_W10_LNon_43bc52bd
  + // No parameters

ends
