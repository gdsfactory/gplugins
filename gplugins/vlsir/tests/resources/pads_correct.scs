// `circuit.Package` `gplugins.klayout.example`
// Generated by `vlsirtools.SpectreNetlister`
//

subckt straight_L392_N2_CSmetal3_W10
  + 1
  + // No parameters

ends

subckt straight_L200_N2_CSmetal3_W10
  + 1
  + // No parameters

ends

subckt straight_L8_N2_CSmetal3_W10
  + 1
  + // No parameters

ends

subckt wire_corner_CSmetal3_RNone
  + 1
  + // No parameters

ends

subckt straight_L400_N2_CSmetal3_W10
  + 1
  + // No parameters

ends

subckt pad_S100_100_LMTOP_BLNo_fdaf576b
  + 1 2
  + // No parameters

ends

subckt pads_correct_Ppad_CSmetal3
  + // No ports
  + // No parameters

  1
  + // Ports:
  + ( tl,tr tl )
  +  pad_S100_100_LMTOP_BLNo_fdaf576b
  + // No parameters

  2
  + // Ports:
  + ( tl,tr tr )
  +  pad_S100_100_LMTOP_BLNo_fdaf576b
  + // No parameters

  3
  + // Ports:
  + ( bl,br br )
  +  pad_S100_100_LMTOP_BLNo_fdaf576b
  + // No parameters

  4
  + // Ports:
  + ( bl,br bl )
  +  pad_S100_100_LMTOP_BLNo_fdaf576b
  + // No parameters

  5
  + // Ports:
  + ( tl,tr )
  +  straight_L8_N2_CSmetal3_W10
  + // No parameters

  6
  + // Ports:
  + ( tl,tr )
  +  wire_corner_CSmetal3_RNone
  + // No parameters

  7
  + // Ports:
  + ( tl,tr )
  +  straight_L200_N2_CSmetal3_W10
  + // No parameters

  8
  + // Ports:
  + ( tl,tr )
  +  wire_corner_CSmetal3_RNone
  + // No parameters

  9
  + // Ports:
  + ( tl,tr )
  +  straight_L392_N2_CSmetal3_W10
  + // No parameters

  10
  + // Ports:
  + ( bl,br )
  +  straight_L400_N2_CSmetal3_W10
  + // No parameters

ends
